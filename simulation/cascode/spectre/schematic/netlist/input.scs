// Design: mylib/cascode
simulator lang=spectre
global 0 vdd!
parameters vac=50u com=1.6
include "/home/vlsidesign/assistant1/SPDK18MMRF_1833_CDS_v2.0/smic18mmrf_1P6M_200709151808/models/spectre/allModels"

// mylib/cascode/schematic
M27 (vdd! net02 net063 0) n33 w=(5u) l=500n m=(1)*(1)
M26 (net02 net02 0 0) n33 w=(500n) l=10u m=(1)*(1)
M25 (net063 net037 0 0) n33 w=(5u) l=500n m=(1)*(1)
M24 (net03 net063 net037 0) n33 w=(350n) l=350n m=(1)*(1)
M20 (net032 net037 0 0) n33 w=(62.5u) l=500n m=(1)*(1)
M13 (net35 net13 0 0) n33 w=(13.5u) l=500n m=(1)*(1)
M12 (net13 net14 net35 0) n33 w=(13.5u) l=500n m=(1)*(1)
M11 (net9 net037 0 0) n33 w=(62.5u) l=500n m=(1)*(1)
M10 (net34 net13 0 0) n33 w=(13.5u) l=500n m=(1)*(1)
M9 (net047 net14 net34 0) n33 w=(13.5u) l=500n m=(1)*(1)
M2 (net26 vin\- net2 0) n33 w=(13.5u) l=500n m=(1)*(1)
M1 (net24 vin\+ net2 0) n33 w=(13.5u) l=500n m=(1)*(1)
M0 (net2 net037 0 0) n33 w=(50u) l=500n m=(1)*(1)
M22 (net03 net03 vdd! vdd!) p33 w=(5u) l=500n m=(1)*(1)
M21 (net063 net03 vdd! vdd!) p33 w=(5u) l=500n m=(1)*(1)
M18 (0 net047 net029 vdd!) p33 w=(20.5u) l=500n m=(1)*(1)
M19 (net032 net029 vdd! vdd!) p33 w=(50u) l=500n m=(1)*(1)
M17 (net029 net10 vdd! vdd!) p33 w=(50u) l=500n m=(1)*(1)
M8 (net047 net9 net26 vdd!) p33 w=(50u) l=500n m=(1)*(1)
M7 (net14 net9 net24 vdd!) p33 w=(50u) l=500n m=(1)*(1)
M6 (net10 net9 net36 vdd!) p33 w=(50u) l=500n m=(1)*(1)
M5 (net36 net10 vdd! vdd!) p33 w=(50u) l=500n m=(1)*(1)
M4 (net26 net10 vdd! vdd!) p33 w=(50u) l=500n m=(1)*(1)
M3 (net24 net10 vdd! vdd!) p33 w=(50u) l=500n m=(1)*(1)
R10 (vdd! net02) resistor r=95K
R8 (net037 0) resistor r=95K
R7 (net047 net21) resistor r=6K
R1 (net14 net13) resistor r=3.3K
R0 (net10 net9) resistor r=3.5K
C0 (net032 net21) capacitor c=3p
CL (net032 0) capacitor c=10p
V1 (vin\- 0) vsource dc=com type=dc
V0 (vdd! 0) vsource dc=3.3 type=dc
V2 (vin\+ vin\-) vsource mag=1 type=sine ampl=vac freq=1K
simulatorOptions options temp=27
dcOp dc
ac ac start=10 stop=100M
tran tran stop=20m
