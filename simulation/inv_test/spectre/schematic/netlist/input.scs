// Design: mylib/inv_test
simulator lang=spectre
global 0 vdd!
parameters vin=0.9
include "/home/vlsidesign/assistant1/SPDK18MMRF_1833_CDS_v2.0/smic18mmrf_1P6M_200709151808/models/spectre/allModels"

// mylib/inverter/schematic
subckt inverter in out
    PM0 (out in vdd! vdd!) p18 w=(1.95u) l=180n m=(1)*(1)
    NM1 (out in 0 0) n18 w=(600n) l=180n m=(1)*(1)
ends inverter

// mylib/inv_test/schematic
I0 (net1 net2) inverter
V0 (vdd! 0) vsource dc=1.8 type=dc
V1 (net1 0) vsource dc=vin mag=1 type=pulse val0=0 val1=1.8 period=10n rise=100p fall=100p width=4.9n
C0 (net2 0) capacitor c=1p
simulatorOptions options temp=27
dcOp dc
dc dc param=vin start=0 stop=1.8 step=0.001
ac ac start=10 stop=1000M
tran tran stop=20n
