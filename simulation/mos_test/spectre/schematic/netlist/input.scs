// Design: mylib/mos_test
simulator lang=spectre
global 0
parameters vds=3.3 vgs_1=0.7 vgs_2=2.6
include "/home/vlsidesign/assistant1/SPDK18MMRF_1833_CDS_v2.0/smic18mmrf_1P6M_200709151808/models/spectre/allModels"

// mylib/mos_test/schematic
M0 (net5 net06 0 0) n33 w=(15u) l=350n m=(1)*(1)
V4 (net011 0) vsource dc=vgs_2 type=dc
V3 (net06 0) vsource dc=vgs_1 type=dc
V0 (net5 0) vsource dc=vds type=dc
M1 (0 net011 net5 net5) p33 w=(15u) l=300n m=(1)*(1)
simulatorOptions options temp=27
dcOp dc
dc dc param=vds start=0 stop=3.3
save M0:d
save M0:rout
