// Design: mylib/op
simulator lang=spectre
global 0 vdd!
parameters vgs=2
include "/home/vlsidesign/assistant1/SPDK18MMRF_1833_CDS_v2.0/smic18mmrf_1P6M_200709151808/models/spectre/allModels"

// mylib/op/schematic
NM0 (net6 net3 0 0) n18 w=(220n) l=180n m=(1)*(1)
R0 (vdd! net6) resistor r=1K
V0 (net3 0) vsource dc=vgs mag=1 type=sine sinedc=vgs ampl=100.0m freq=1K
V1 (vdd! 0) vsource dc=3.3 type=dc
simulatorOptions options temp=27
dc dc param=vgs start=0 stop=4
tran tran stop=2m
ac ac start=0 stop=100M
