// Design: mylib/op_test
simulator lang=spectre
global 0 vdd!
parameters vac=1 vcom=1.6
include "/home/vlsidesign/assistant1/SPDK18MMRF_1833_CDS_v2.0/smic18mmrf_1P6M_200709151808/models/spectre/allModels"

// mylib/cascode_op/schematic
subckt cascode_op vin\+ vin\- vout
    M20 (vout net037 0 0) n33 w=(62.5u) l=500n m=(1)*(1)
    M27 (vdd! net02 net063 0) n33 w=(5u) l=500n m=(1)*(1)
    M25 (net063 net037 0 0) n33 w=(5u) l=500n m=(1)*(1)
    M24 (net03 net063 net037 0) n33 w=(350n) l=350n m=(1)*(1)
    M26 (net02 net02 0 0) n33 w=(500n) l=10u m=(1)*(1)
    M13 (net34 net13 0 0) n33 w=(10u) l=500n m=(1)*(1)
    M12 (net13 net9 net34 0) n33 w=(20u) l=500n m=(1)*(1)
    M11 (net9 net037 0 0) n33 w=(625n) l=500n m=(1)*(1)
    M10 (net35 net13 0 0) n33 w=(10u) l=500n m=(1)*(1)
    M9 (net056 net9 net35 0) n33 w=(20u) l=500n m=(1)*(1)
    M2 (net26 vin\+ net2 0) n33 w=(20u) l=500n m=(1)*(1)
    M1 (net24 vin\- net2 0) n33 w=(20u) l=500n m=(1)*(1)
    M0 (net2 net037 0 0) n33 w=(75u) l=500n m=(1)*(1)
    M32 (net35 vin\+ net020 vdd!) p33 w=(13.5u) l=500n m=(1)*(1)
    M22 (net03 net03 vdd! vdd!) p33 w=(5u) l=500n m=(1)*(1)
    M21 (net063 net03 vdd! vdd!) p33 w=(5u) l=500n m=(1)*(1)
    M18 (0 net056 net029 vdd!) p33 w=(5.2u) l=500n m=(1)*(1)
    M19 (vout net029 vdd! vdd!) p33 w=(50u) l=500n m=(1)*(1)
    M30 (net020 net03 vdd! vdd!) p33 w=(75u) l=500n m=(1)*(1)
    M28 (net34 vin\- net020 vdd!) p33 w=(13.5u) l=500n m=(1)*(1)
    M17 (net029 net10 vdd! vdd!) p33 w=(10u) l=500n m=(1)*(1)
    M8 (net056 net9 net26 vdd!) p33 w=(50u) l=500n m=(1)*(1)
    M7 (net13 net9 net24 vdd!) p33 w=(50u) l=500n m=(1)*(1)
    M6 (net10 net9 net36 vdd!) p33 w=(500n) l=500n m=(1)*(1)
    M5 (net36 net10 vdd! vdd!) p33 w=(500n) l=500n m=(1)*(1)
    M4 (net26 net10 vdd! vdd!) p33 w=(50u) l=500n m=(1)*(1)
    M3 (net24 net10 vdd! vdd!) p33 w=(50u) l=500n m=(1)*(1)
    R10 (vdd! net02) resistor r=95K
    R8 (net037 0) resistor r=95K
    R7 (net056 net21) resistor r=6.5K
    R0 (net10 net9) resistor r=500K
    C0 (vout net21) capacitor c=4p
ends cascode_op

// mylib/op_test/schematic
V2 (net04 net06) vsource mag=1 type=sine ampl=vac freq=1K
V1 (net06 0) vsource dc=vcom type=dc
V0 (vdd! 0) vsource dc=3.3 type=dc
I4 (net04 net011 net011) cascode_op
C0 (net011 0) capacitor c=10p
simulatorOptions options temp=27
dcOp dc
dc dc param=vcom start=0 stop=3.3
ac ac start=1 stop=1G
tran tran stop=10m
pz ( net7 0 ) pz iprobe=V2 freq=1
